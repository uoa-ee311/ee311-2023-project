# Ansys Electronics Desktop project, version 2021.1
materials:
  vacuum: permittivity=1
  copper: permeability=0.999991 conductivity=58000000
  ferrite: permittivity=12 permeability=1000 conductivity=0.01
  N87: permittivity=12 permeability=2200 conductivity=0.01

design Maxwell3DDesign4 (Maxwell 3D, EddyCurrent, model units mm)
geometry:
  C61036A0103C0180106 [N87] = imported_body(C:\Users\skim281\Downloads\c61036-a0103-c001_ETD34.stp)
  C61036A0103C0180106_1 [N87] = C61036A0103C0180106.duplicate_mirror(point=(0mm, 17.5mm, 0mm), normal=(0mm, 1mm, 0mm))
  C61036A0103C0180106_1.move(0mm, 0.1mm, 0mm)
  Cylinder1 = cylinder(axis=Y, base_centre=(0mm, 7.2mm, 0mm), radius=5.55mm, height=20.6mm)
  Cylinder2 = cylinder(axis=Y, base_centre=(0mm, 7.2mm, 0mm), radius=5.95mm, height=20.6mm)
  Cylinder3 [copper] = cylinder(axis=Y, base_centre=(0mm, 7.2mm, 0mm), radius=6.35mm, height=20.6mm)
  Cylinder3.subtract(Cylinder2)
  Cylinder4 [copper] = cylinder(axis=Y, base_centre=(0mm, 7.2mm, 0mm), radius=5.95mm, height=20.6mm)
  Cylinder4.subtract(Cylinder1)
  Region [vacuum] = region(absolute_offset=500mm on all sides)
  Cylinder3_Section1 [copper] = Cylinder3.section(plane=XY)
  Cylinder4_Section1 [copper] = Cylinder4.section(plane=XY)
  Cylinder3_Section1.separate_bodies()
  Cylinder4_Section1.separate_bodies()
  Rectangle1 [non-model] = rectangle(corner=(-50mm, -32.45mm, 0mm), x_size=100mm, y_size=100mm)
  Ellipse1 [non-model] = ellipse(normal=Y, centre=(0mm, 10.55mm, 0mm), major_radius=5.55mm, ratio=1)
  group c61036a0103c001_ETD34 = C61036A0103C0180106, C61036A0103C0180106_1
boundaries and excitations:
  Insulating1: Insulating Objects=Cylinder4
  CoilTerminal1: Coil Terminal Objects=Cylinder3_Section1 Conductor_number=8 Winding=Winding1 Point_out_of_terminal=false
  CoilTerminal2: Coil Terminal Objects=Cylinder4_Section1 Conductor_number=8 Winding=Winding2 Point_out_of_terminal=false
  Winding1: Winding Group Type=Current IsSolid=false Current=1.225A ParallelBranchesNum=1 Phase=0deg
  Winding2: Winding Group Type=Current IsSolid=false Current=0A ParallelBranchesNum=1 Phase=0deg
parameters:
  Matrix1: Matrix Winding1, Winding2:
mesh:
  initial mesh: GlobalCurvilinear{Apply}
setups:
  Setup1: EddyCurrent MaximumPasses=10 MinimumPasses=2 MinimumConvergedPasses=1 PercentRefinement=30 PercentError=1 NonLinearResidual=0.0001 Frequency=100kHz
field plots:
  Mag_B1, Mag_B2: B over a plane on Setup1 : LastAdaptive at Freq=100kHz Phase=0deg
reports:
  L Table 1: Matrix1.L(Winding1,Winding1), Matrix1.L(Winding1,Winding2), Matrix1.L(Winding2,Winding2), Matrix1.CplCoef(Winding1,Winding2) vs Freq on Setup1 : LastAdaptive
